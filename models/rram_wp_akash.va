`include "disciplines.vams"
`include "constants.vams"

module RRAM_v0(t, b, nGap);
    inout t, b, nGap;
    electrical t, b, nGap;
    parameter real g0 = 0.25 from (0:inf);
    parameter real V0 = 0.25 from (0:inf);
    parameter real Vel0 = 10 from (0:inf);
    parameter real I0 = 1e-3 from (0:inf);
    parameter real Beta = 0.8 from (0:inf);
    parameter real gamma0 = 16 from (0:inf);
    parameter real Ea = 0.6 from (0:inf);
    parameter real a0 = 0.25 from (0:inf);
    parameter real tox = 12 from (0:inf);

    parameter real maxGap = 1.7 from (0:inf);
    parameter real minGap = 0.2 from (0:inf);

    parameter real smoothing = 1e-8 from (0:inf);
    parameter real GMIN = 1e-12 from (0:inf);
    parameter real Kclip = 50 from (0:inf);

    real Gap, ddt_gap, Gamma, Fw1, Fw2, clip_0, clip_maxGap;

    `include "smoothfunctions.va"

    analog begin
        Gap = V(nGap, b);
        I(t, b) <+ I0 * safeexp(-Gap/g0, smoothing) * safesinh(V(t, b)/V0, smoothing) + GMIN*V(t, b);

        Gamma = gamma0 - Beta * pow(Gap, 3);
        ddt_gap = -Vel0*safeexp(-Ea/$vt, smoothing)*safesinh(V(t, b)*Gamma*a0/tox/$vt, smoothing);

        Fw1 = smoothstep(minGap-Gap, smoothing);
        Fw2 = smoothstep(Gap-maxGap, smoothing);
        clip_minGap = (safeexp(Kclip*(minGap-Gap), smoothing) - ddt_gap) * Fw1;
        clip_maxGap = (-safeexp(Kclip*(Gap-maxGap), smoothing) - ddt_gap) * Fw2;

        I(nGap, b) <+ ddt_gap + clip_minGap + clip_maxGap;
        I(nGap, b) <+ ddt(-1e-9*Gap);
    end
endmodule
